# Ansys Electronics Desktop project, version 2023.2
materials:
  vacuum: permittivity=1
  Duroid (tm): permittivity=2.2 dielectric_loss_tangent=0.0009

design HFSSDesign1 (HFSS, HFSS Terminal Network, model units mm)
geometry:
  Substrate [Duroid (tm)] = box(corner=(-30mm, -30mm, 0mm), size=(60mm, 60mm, 1.295mm))
  XPatch1 = rectangle(corner=(-16.5mm, -16.5mm, 1.295mm), x_size=9mm, y_size=9mm)
  coordinate_system RelativeCS1 = origin=(-12mm, -12mm, 1.295mm) x=(1mm, 0mm, 0mm) y=(0mm, 1mm, 0mm)
  Xperf1 = rectangle(corner=(-3.9mm, -3.9mm, 0mm), x_size=2.8mm, y_size=2.8mm) in RelativeCS1
  Xperf2 = rectangle(corner=(0.9mm, -3.9mm, 0mm), x_size=2.8mm, y_size=2.8mm) in RelativeCS1
  Xperf3 = rectangle(corner=(0.9mm, 0.9mm, 0mm), x_size=2.8mm, y_size=2.8mm) in RelativeCS1
  Xperf4 = rectangle(corner=(-3.9mm, 0.9mm, 0mm), x_size=2.8mm, y_size=2.8mm) in RelativeCS1
  XPatch1.subtract(Xperf1..Xperf4)
  XPatch2 = rectangle(corner=(-16.5mm, -16.5mm, 1.295mm), x_size=9mm, y_size=9mm)
  coordinate_system RelativeCS2 = origin=(-12mm, -12mm, 1.295mm) x=(1mm, 0mm, 0mm) y=(0mm, 1mm, 0mm)
  Xperf5 = rectangle(corner=(-3.9mm, -3.9mm, 0mm), x_size=2.8mm, y_size=2.8mm) in RelativeCS2
  Xperf6 = rectangle(corner=(0.9mm, -3.9mm, 0mm), x_size=2.8mm, y_size=2.8mm) in RelativeCS2
  Xperf7 = rectangle(corner=(0.9mm, 0.9mm, 0mm), x_size=2.8mm, y_size=2.8mm) in RelativeCS2
  Xperf8 = rectangle(corner=(-3.9mm, 0.9mm, 0mm), x_size=2.8mm, y_size=2.8mm) in RelativeCS2
  XPatch2.subtract(Xperf5..Xperf8)
  XPatch2.move(0mm, 24mm, 0mm)
  XPatch3 = rectangle(corner=(-16.5mm, -16.5mm, 1.295mm), x_size=9mm, y_size=9mm)
  coordinate_system RelativeCS3 = origin=(-12mm, -12mm, 1.295mm) x=(1mm, 0mm, 0mm) y=(0mm, 1mm, 0mm)
  Xperf9 = rectangle(corner=(-3.9mm, -3.9mm, 0mm), x_size=2.8mm, y_size=2.8mm) in RelativeCS3
  Xperf10 = rectangle(corner=(0.9mm, -3.9mm, 0mm), x_size=2.8mm, y_size=2.8mm) in RelativeCS3
  Xperf11 = rectangle(corner=(0.9mm, 0.9mm, 0mm), x_size=2.8mm, y_size=2.8mm) in RelativeCS3
  Xperf12 = rectangle(corner=(-3.9mm, 0.9mm, 0mm), x_size=2.8mm, y_size=2.8mm) in RelativeCS3
  XPatch3.subtract(Xperf9..Xperf12)
  XPatch3.move(24mm, 0mm, 0mm)
  XPatch4 = rectangle(corner=(-16.5mm, -16.5mm, 1.295mm), x_size=9mm, y_size=9mm)
  coordinate_system RelativeCS4 = origin=(-12mm, -12mm, 1.295mm) x=(1mm, 0mm, 0mm) y=(0mm, 1mm, 0mm)
  Xperf13 = rectangle(corner=(-3.9mm, -3.9mm, 0mm), x_size=2.8mm, y_size=2.8mm) in RelativeCS4
  Xperf14 = rectangle(corner=(0.9mm, -3.9mm, 0mm), x_size=2.8mm, y_size=2.8mm) in RelativeCS4
  Xperf15 = rectangle(corner=(0.9mm, 0.9mm, 0mm), x_size=2.8mm, y_size=2.8mm) in RelativeCS4
  Xperf16 = rectangle(corner=(-3.9mm, 0.9mm, 0mm), x_size=2.8mm, y_size=2.8mm) in RelativeCS4
  XPatch4.subtract(Xperf13..Xperf16)
  XPatch4.move(24mm, 24mm, 0mm)
  KuPatch1 = rectangle(corner=(-3.55mm, -0.3mm, 1.295mm), x_size=7.1mm, y_size=0.6mm)
  KuPatch1_5 = rectangle(corner=(-3.55mm, -0.3mm, 1.295mm), x_size=7.1mm, y_size=0.6mm)
  KuPatch1_5.rotate(axis=Z, angle=90deg)
  KuPatch1_5.unite(KuPatch1)
  KuPatch1_5.move(-18mm, -18mm, 0mm)
  KaPatch11 = rectangle(corner=(-4.05mm, -4.05mm, 1.295mm), x_size=2.1mm, y_size=2.1mm)
  KaPatch11.move(-6.5mm, -6.5mm, 0mm)
  KuPatch1_6 = rectangle(corner=(-3.55mm, -0.3mm, 1.295mm), x_size=7.1mm, y_size=0.6mm)
  KuPatch1_6.rotate(axis=Z, angle=90deg)
  KuPatch2 = rectangle(corner=(-3.55mm, -0.3mm, 1.295mm), x_size=7.1mm, y_size=0.6mm)
  KuPatch1_6.unite(KuPatch2)
  KuPatch1_6.move(-18mm, -18mm, 0mm)
  KuPatch1_6.move(0mm, 12mm, 0mm)
  KuPatch1_7 = rectangle(corner=(-3.55mm, -0.3mm, 1.295mm), x_size=7.1mm, y_size=0.6mm)
  KuPatch1_7.rotate(axis=Z, angle=90deg)
  KuPatch3 = rectangle(corner=(-3.55mm, -0.3mm, 1.295mm), x_size=7.1mm, y_size=0.6mm)
  KuPatch1_7.unite(KuPatch3)
  KuPatch1_7.move(-18mm, -18mm, 0mm)
  KuPatch1_7.move(0mm, 12mm, 0mm)
  KuPatch1_8 = rectangle(corner=(-3.55mm, -0.3mm, 1.295mm), x_size=7.1mm, y_size=0.6mm)
  KuPatch1_8.rotate(axis=Z, angle=90deg)
  KuPatch4 = rectangle(corner=(-3.55mm, -0.3mm, 1.295mm), x_size=7.1mm, y_size=0.6mm)
  KuPatch1_8.unite(KuPatch4)
  KuPatch1_8.move(-18mm, -18mm, 0mm)
  [KuPatch1_7, KuPatch1_8].move(0mm, 24mm, 0mm)
  KuPatch1_9 = rectangle(corner=(-3.55mm, -0.3mm, 1.295mm), x_size=7.1mm, y_size=0.6mm)
  KuPatch1_9.rotate(axis=Z, angle=90deg)
  KuPatch5 = rectangle(corner=(-3.55mm, -0.3mm, 1.295mm), x_size=7.1mm, y_size=0.6mm)
  KuPatch1_9.unite(KuPatch5)
  KuPatch1_9.move(-18mm, -18mm, 0mm)
  KuPatch1_10 = rectangle(corner=(-3.55mm, -0.3mm, 1.295mm), x_size=7.1mm, y_size=0.6mm)
  KuPatch1_10.rotate(axis=Z, angle=90deg)
  KuPatch6 = rectangle(corner=(-3.55mm, -0.3mm, 1.295mm), x_size=7.1mm, y_size=0.6mm)
  KuPatch1_10.unite(KuPatch6)
  KuPatch1_10.move(-18mm, -18mm, 0mm)
  KuPatch1_10.move(0mm, 12mm, 0mm)
  KuPatch1_11 = rectangle(corner=(-3.55mm, -0.3mm, 1.295mm), x_size=7.1mm, y_size=0.6mm)
  KuPatch1_11.rotate(axis=Z, angle=90deg)
  KuPatch7 = rectangle(corner=(-3.55mm, -0.3mm, 1.295mm), x_size=7.1mm, y_size=0.6mm)
  KuPatch1_11.unite(KuPatch7)
  KuPatch1_11.move(-18mm, -18mm, 0mm)
  KuPatch1_11.move(0mm, 12mm, 0mm)
  KuPatch1_11.move(0mm, 24mm, 0mm)
  KuPatch1_12 = rectangle(corner=(-3.55mm, -0.3mm, 1.295mm), x_size=7.1mm, y_size=0.6mm)
  KuPatch1_12.rotate(axis=Z, angle=90deg)
  KuPatch8 = rectangle(corner=(-3.55mm, -0.3mm, 1.295mm), x_size=7.1mm, y_size=0.6mm)
  KuPatch1_12.unite(KuPatch8)
  KuPatch1_12.move(-18mm, -18mm, 0mm)
  KuPatch1_12.move(0mm, 24mm, 0mm)
  [KuPatch1_9..KuPatch1_12].move(12mm, 0mm, 0mm)
  KuPatch1_13 = rectangle(corner=(-3.55mm, -0.3mm, 1.295mm), x_size=7.1mm, y_size=0.6mm)
  KuPatch1_13.rotate(axis=Z, angle=90deg)
  KuPatch9 = rectangle(corner=(-3.55mm, -0.3mm, 1.295mm), x_size=7.1mm, y_size=0.6mm)
  KuPatch1_13.unite(KuPatch9)
  KuPatch1_13.move(-18mm, -18mm, 0mm)
  KuPatch1_14 = rectangle(corner=(-3.55mm, -0.3mm, 1.295mm), x_size=7.1mm, y_size=0.6mm)
  KuPatch1_14.rotate(axis=Z, angle=90deg)
  KuPatch10 = rectangle(corner=(-3.55mm, -0.3mm, 1.295mm), x_size=7.1mm, y_size=0.6mm)
  KuPatch1_14.unite(KuPatch10)
  KuPatch1_14.move(-18mm, -18mm, 0mm)
  KuPatch1_14.move(0mm, 12mm, 0mm)
  KuPatch1_15 = rectangle(corner=(-3.55mm, -0.3mm, 1.295mm), x_size=7.1mm, y_size=0.6mm)
  KuPatch1_15.rotate(axis=Z, angle=90deg)
  KuPatch11 = rectangle(corner=(-3.55mm, -0.3mm, 1.295mm), x_size=7.1mm, y_size=0.6mm)
  KuPatch1_15.unite(KuPatch11)
  KuPatch1_15.move(-18mm, -18mm, 0mm)
  KuPatch1_15.move(0mm, 12mm, 0mm)
  KuPatch1_15.move(0mm, 24mm, 0mm)
  KuPatch1_16 = rectangle(corner=(-3.55mm, -0.3mm, 1.295mm), x_size=7.1mm, y_size=0.6mm)
  KuPatch1_16.rotate(axis=Z, angle=90deg)
  KuPatch12 = rectangle(corner=(-3.55mm, -0.3mm, 1.295mm), x_size=7.1mm, y_size=0.6mm)
  KuPatch1_16.unite(KuPatch12)
  KuPatch1_16.move(-18mm, -18mm, 0mm)
  KuPatch1_16.move(0mm, 24mm, 0mm)
  KuPatch1_17 = rectangle(corner=(-3.55mm, -0.3mm, 1.295mm), x_size=7.1mm, y_size=0.6mm)
  KuPatch1_17.rotate(axis=Z, angle=90deg)
  KuPatch13 = rectangle(corner=(-3.55mm, -0.3mm, 1.295mm), x_size=7.1mm, y_size=0.6mm)
  KuPatch1_17.unite(KuPatch13)
  KuPatch1_17.move(-18mm, -18mm, 0mm)
  KuPatch1_17.move(12mm, 0mm, 0mm)
  KuPatch1_18 = rectangle(corner=(-3.55mm, -0.3mm, 1.295mm), x_size=7.1mm, y_size=0.6mm)
  KuPatch1_18.rotate(axis=Z, angle=90deg)
  KuPatch14 = rectangle(corner=(-3.55mm, -0.3mm, 1.295mm), x_size=7.1mm, y_size=0.6mm)
  KuPatch1_18.unite(KuPatch14)
  KuPatch1_18.move(-18mm, -18mm, 0mm)
  KuPatch1_18.move(0mm, 12mm, 0mm)
  KuPatch1_18.move(12mm, 0mm, 0mm)
  KuPatch1_19 = rectangle(corner=(-3.55mm, -0.3mm, 1.295mm), x_size=7.1mm, y_size=0.6mm)
  KuPatch1_19.rotate(axis=Z, angle=90deg)
  KuPatch15 = rectangle(corner=(-3.55mm, -0.3mm, 1.295mm), x_size=7.1mm, y_size=0.6mm)
  KuPatch1_19.unite(KuPatch15)
  KuPatch1_19.move(-18mm, -18mm, 0mm)
  KuPatch1_19.move(0mm, 12mm, 0mm)
  KuPatch1_19.move(0mm, 24mm, 0mm)
  KuPatch1_19.move(12mm, 0mm, 0mm)
  KuPatch1_20 = rectangle(corner=(-3.55mm, -0.3mm, 1.295mm), x_size=7.1mm, y_size=0.6mm)
  KuPatch1_20.rotate(axis=Z, angle=90deg)
  KuPatch16 = rectangle(corner=(-3.55mm, -0.3mm, 1.295mm), x_size=7.1mm, y_size=0.6mm)
  KuPatch1_20.unite(KuPatch16)
  KuPatch1_20.move(-18mm, -18mm, 0mm)
  KuPatch1_20.move(0mm, 24mm, 0mm)
  KuPatch1_20.move(12mm, 0mm, 0mm)
  [KuPatch1_13..KuPatch1_20].move(24mm, 0mm, 0mm)
  KaPatch12 = rectangle(corner=(-4.05mm, -4.05mm, 1.295mm), x_size=2.1mm, y_size=2.1mm)
  KaPatch12.move(-6.5mm, -6.5mm, 0mm)
  KaPatch12.move(0mm, 6.5mm, 0mm)
  KaPatch13 = rectangle(corner=(-4.05mm, -4.05mm, 1.295mm), x_size=2.1mm, y_size=2.1mm)
  KaPatch13.move(-6.5mm, -6.5mm, 0mm)
  KaPatch14 = rectangle(corner=(-4.05mm, -4.05mm, 1.295mm), x_size=2.1mm, y_size=2.1mm)
  KaPatch14.move(-6.5mm, -6.5mm, 0mm)
  KaPatch14.move(0mm, 6.5mm, 0mm)
  [KaPatch14, KaPatch13].move(0mm, 12.5mm, 0mm)
  KaPatch15 = rectangle(corner=(-4.05mm, -4.05mm, 1.295mm), x_size=2.1mm, y_size=2.1mm)
  KaPatch15.move(-6.5mm, -6.5mm, 0mm)
  KaPatch16 = rectangle(corner=(-4.05mm, -4.05mm, 1.295mm), x_size=2.1mm, y_size=2.1mm)
  KaPatch16.move(-6.5mm, -6.5mm, 0mm)
  KaPatch16.move(0mm, 6.5mm, 0mm)
  KaPatch17 = rectangle(corner=(-4.05mm, -4.05mm, 1.295mm), x_size=2.1mm, y_size=2.1mm)
  KaPatch17.move(-6.5mm, -6.5mm, 0mm)
  KaPatch17.move(0mm, 12.5mm, 0mm)
  KaPatch18 = rectangle(corner=(-4.05mm, -4.05mm, 1.295mm), x_size=2.1mm, y_size=2.1mm)
  KaPatch18.move(-6.5mm, -6.5mm, 0mm)
  KaPatch18.move(0mm, 6.5mm, 0mm)
  KaPatch18.move(0mm, 12.5mm, 0mm)
  [KaPatch15..KaPatch18].move(6mm, 0mm, 0mm)
  KaPatch19 = rectangle(corner=(-4.05mm, -4.05mm, 1.295mm), x_size=2.1mm, y_size=2.1mm)
  KaPatch19.move(-6.5mm, -6.5mm, 0mm)
  KaPatch19.move(6mm, 0mm, 0mm)
  KaPatch20 = rectangle(corner=(-4.05mm, -4.05mm, 1.295mm), x_size=2.1mm, y_size=2.1mm)
  KaPatch20.move(-6.5mm, -6.5mm, 0mm)
  KaPatch20.move(0mm, 6.5mm, 0mm)
  KaPatch20.move(6mm, 0mm, 0mm)
  KaPatch21 = rectangle(corner=(-4.05mm, -4.05mm, 1.295mm), x_size=2.1mm, y_size=2.1mm)
  KaPatch21.move(-6.5mm, -6.5mm, 0mm)
  KaPatch21.move(0mm, 12.5mm, 0mm)
  KaPatch21.move(6mm, 0mm, 0mm)
  KaPatch22 = rectangle(corner=(-4.05mm, -4.05mm, 1.295mm), x_size=2.1mm, y_size=2.1mm)
  KaPatch22.move(-6.5mm, -6.5mm, 0mm)
  KaPatch22.move(0mm, 6.5mm, 0mm)
  KaPatch22.move(0mm, 12.5mm, 0mm)
  KaPatch22.move(6mm, 0mm, 0mm)
  [KaPatch19..KaPatch22].move(13mm, 0mm, 0mm)
  KaPatch23 = rectangle(corner=(-4.05mm, -4.05mm, 1.295mm), x_size=2.1mm, y_size=2.1mm)
  KaPatch23.move(-6.5mm, -6.5mm, 0mm)
  KaPatch23.move(6mm, 0mm, 0mm)
  KaPatch23.move(13mm, 0mm, 0mm)
  KaPatch24 = rectangle(corner=(-4.05mm, -4.05mm, 1.295mm), x_size=2.1mm, y_size=2.1mm)
  KaPatch24.move(-6.5mm, -6.5mm, 0mm)
  KaPatch24.move(0mm, 6.5mm, 0mm)
  KaPatch24.move(6mm, 0mm, 0mm)
  KaPatch24.move(13mm, 0mm, 0mm)
  KaPatch25 = rectangle(corner=(-4.05mm, -4.05mm, 1.295mm), x_size=2.1mm, y_size=2.1mm)
  KaPatch25.move(-6.5mm, -6.5mm, 0mm)
  KaPatch25.move(0mm, 12.5mm, 0mm)
  KaPatch25.move(6mm, 0mm, 0mm)
  KaPatch25.move(13mm, 0mm, 0mm)
  KaPatch26 = rectangle(corner=(-4.05mm, -4.05mm, 1.295mm), x_size=2.1mm, y_size=2.1mm)
  KaPatch26.move(-6.5mm, -6.5mm, 0mm)
  KaPatch26.move(0mm, 6.5mm, 0mm)
  KaPatch26.move(0mm, 12.5mm, 0mm)
  KaPatch26.move(6mm, 0mm, 0mm)
  KaPatch26.move(13mm, 0mm, 0mm)
  [KaPatch23..KaPatch26].move(-6mm, 0mm, 0mm)
  KaPatch35 = rectangle(corner=(-4.05mm, -4.05mm, 1.295mm), x_size=2.1mm, y_size=2.1mm)
  KaPatch35.move(-6.5mm, -6.5mm, 0mm)
  KaPatch36 = rectangle(corner=(-4.05mm, -4.05mm, 1.295mm), x_size=2.1mm, y_size=2.1mm)
  KaPatch36.move(-6.5mm, -6.5mm, 0mm)
  KaPatch36.move(0mm, 6.5mm, 0mm)
  KaPatch37 = rectangle(corner=(-4.05mm, -4.05mm, 1.295mm), x_size=2.1mm, y_size=2.1mm)
  KaPatch37.move(-6.5mm, -6.5mm, 0mm)
  KaPatch37.move(0mm, 12.5mm, 0mm)
  KaPatch38 = rectangle(corner=(-4.05mm, -4.05mm, 1.295mm), x_size=2.1mm, y_size=2.1mm)
  KaPatch38.move(-6.5mm, -6.5mm, 0mm)
  KaPatch38.move(0mm, 6.5mm, 0mm)
  KaPatch38.move(0mm, 12.5mm, 0mm)
  KaPatch39 = rectangle(corner=(-4.05mm, -4.05mm, 1.295mm), x_size=2.1mm, y_size=2.1mm)
  KaPatch39.move(-6.5mm, -6.5mm, 0mm)
  KaPatch39.move(6mm, 0mm, 0mm)
  KaPatch40 = rectangle(corner=(-4.05mm, -4.05mm, 1.295mm), x_size=2.1mm, y_size=2.1mm)
  KaPatch40.move(-6.5mm, -6.5mm, 0mm)
  KaPatch40.move(0mm, 6.5mm, 0mm)
  KaPatch40.move(6mm, 0mm, 0mm)
  KaPatch41 = rectangle(corner=(-4.05mm, -4.05mm, 1.295mm), x_size=2.1mm, y_size=2.1mm)
  KaPatch41.move(-6.5mm, -6.5mm, 0mm)
  KaPatch41.move(0mm, 12.5mm, 0mm)
  KaPatch41.move(6mm, 0mm, 0mm)
  KaPatch42 = rectangle(corner=(-4.05mm, -4.05mm, 1.295mm), x_size=2.1mm, y_size=2.1mm)
  KaPatch42.move(-6.5mm, -6.5mm, 0mm)
  KaPatch42.move(0mm, 6.5mm, 0mm)
  KaPatch42.move(0mm, 12.5mm, 0mm)
  KaPatch42.move(6mm, 0mm, 0mm)
  KaPatch43 = rectangle(corner=(-4.05mm, -4.05mm, 1.295mm), x_size=2.1mm, y_size=2.1mm)
  KaPatch43.move(-6.5mm, -6.5mm, 0mm)
  KaPatch43.move(6mm, 0mm, 0mm)
  KaPatch43.move(13mm, 0mm, 0mm)
  KaPatch44 = rectangle(corner=(-4.05mm, -4.05mm, 1.295mm), x_size=2.1mm, y_size=2.1mm)
  KaPatch44.move(-6.5mm, -6.5mm, 0mm)
  KaPatch44.move(0mm, 6.5mm, 0mm)
  KaPatch44.move(6mm, 0mm, 0mm)
  KaPatch44.move(13mm, 0mm, 0mm)
  KaPatch45 = rectangle(corner=(-4.05mm, -4.05mm, 1.295mm), x_size=2.1mm, y_size=2.1mm)
  KaPatch45.move(-6.5mm, -6.5mm, 0mm)
  KaPatch45.move(0mm, 12.5mm, 0mm)
  KaPatch45.move(6mm, 0mm, 0mm)
  KaPatch45.move(13mm, 0mm, 0mm)
  KaPatch46 = rectangle(corner=(-4.05mm, -4.05mm, 1.295mm), x_size=2.1mm, y_size=2.1mm)
  KaPatch46.move(-6.5mm, -6.5mm, 0mm)
  KaPatch46.move(0mm, 6.5mm, 0mm)
  KaPatch46.move(0mm, 12.5mm, 0mm)
  KaPatch46.move(6mm, 0mm, 0mm)
  KaPatch46.move(13mm, 0mm, 0mm)
  KaPatch47 = rectangle(corner=(-4.05mm, -4.05mm, 1.295mm), x_size=2.1mm, y_size=2.1mm)
  KaPatch47.move(-6.5mm, -6.5mm, 0mm)
  KaPatch47.move(6mm, 0mm, 0mm)
  KaPatch47.move(13mm, 0mm, 0mm)
  KaPatch47.move(-6mm, 0mm, 0mm)
  KaPatch48 = rectangle(corner=(-4.05mm, -4.05mm, 1.295mm), x_size=2.1mm, y_size=2.1mm)
  KaPatch48.move(-6.5mm, -6.5mm, 0mm)
  KaPatch48.move(0mm, 6.5mm, 0mm)
  KaPatch48.move(6mm, 0mm, 0mm)
  KaPatch48.move(13mm, 0mm, 0mm)
  KaPatch48.move(-6mm, 0mm, 0mm)
  KaPatch49 = rectangle(corner=(-4.05mm, -4.05mm, 1.295mm), x_size=2.1mm, y_size=2.1mm)
  KaPatch49.move(-6.5mm, -6.5mm, 0mm)
  KaPatch49.move(0mm, 12.5mm, 0mm)
  KaPatch49.move(6mm, 0mm, 0mm)
  KaPatch49.move(13mm, 0mm, 0mm)
  KaPatch49.move(-6mm, 0mm, 0mm)
  KaPatch50 = rectangle(corner=(-4.05mm, -4.05mm, 1.295mm), x_size=2.1mm, y_size=2.1mm)
  KaPatch50.move(-6.5mm, -6.5mm, 0mm)
  KaPatch50.move(0mm, 6.5mm, 0mm)
  KaPatch50.move(0mm, 12.5mm, 0mm)
  KaPatch50.move(6mm, 0mm, 0mm)
  KaPatch50.move(13mm, 0mm, 0mm)
  KaPatch50.move(-6mm, 0mm, 0mm)
  [KaPatch35..KaPatch50].move(0mm, 0mm, -0.787mm)
  XFeed = rectangle(corner=(-24mm, -40mm, 0mm), x_size=10mm, y_size=0.8mm)
  XFeed.move(1.5mm, 27.5mm, 0mm)
  XFeedr = rectangle(corner=(-16mm, -48mm, 0mm), x_size=0.8mm, y_size=10mm)
  XFeedr.move(5.5mm, 31mm, 0mm)
  XFeedr.move(0mm, -2mm, 0mm)
  XFeed1 = rectangle(corner=(-24mm, -40mm, 0mm), x_size=10mm, y_size=0.8mm)
  XFeed1.move(1.5mm, 27.5mm, 0mm)
  XFeed1.move(0mm, 24mm, 0mm)
  XFeedr1 = rectangle(corner=(-16mm, -48mm, 0mm), x_size=0.8mm, y_size=10mm)
  XFeedr1.move(5.5mm, 31mm, 0mm)
  XFeedr1.move(0mm, -2mm, 0mm)
  XFeedr1.move(0mm, 28mm, 0mm)
  XFeedr2 = rectangle(corner=(-16mm, -48mm, 0mm), x_size=0.8mm, y_size=10mm)
  XFeedr2.move(5.5mm, 31mm, 0mm)
  XFeedr2.move(0mm, -2mm, 0mm)
  XFeedr3 = rectangle(corner=(-16mm, -48mm, 0mm), x_size=0.8mm, y_size=10mm)
  XFeedr3.move(5.5mm, 31mm, 0mm)
  XFeedr3.move(0mm, -2mm, 0mm)
  XFeedr3.move(0mm, 28mm, 0mm)
  [XFeedr2, XFeedr3].move(19mm, 0mm, 0mm)
  [XFeed, XFeed1, XFeedr, XFeedr1, XFeedr2, XFeedr3].move(0mm, 66mm, 0mm)
  [XFeed, XFeedr, XFeed1, XFeedr1, XFeedr2, XFeedr3].move(0mm, -68.5mm, 0mm)
  [XFeed1, XFeedr1, XFeedr3].move(0mm, 5mm, 0mm)
  Ground, Rectangle1, Rectangle16 [vacuum] = imported_body()
  Rectangle17 = rectangle(corner=(-10.5mm, -21.5mm, 0mm), x_size=19.8mm, y_size=-0.2mm)
  Rectangle19 = rectangle(corner=(-10.5mm, 21.5mm, 0mm), x_size=19.8mm, y_size=0.2mm)
  XFeedr.unite(XFeedr2, Rectangle17)
  XFeedr1.unite(XFeedr3, Rectangle19)
  Rectangle20 = rectangle(corner=(-23mm, -15mm, 0mm), x_size=0.2mm, y_size=30mm)
  Rectangle20.move(0.3mm, -0.15mm, 0mm)
  XFeed.unite(XFeed1, Rectangle20)
  XFeed_1 = XFeed.duplicate_mirror(point=(0mm, 36mm, 0mm), normal=(1mm, 0mm, 0mm))
  Rectangle34 [vacuum] = imported_body()
  Rectangle35 = rectangle(corner=(-0.1mm, 21.7mm, 0mm), x_size=0.2mm, y_size=8.3mm)
  Rectangle36 = rectangle(corner=(-22.7mm, -0.2mm, 0mm), x_size=-3.3mm, y_size=0.4mm)
  Rectangle36.unite(XFeed)
  Rectangle37 = rectangle(corner=(-26.2mm, -0.2mm, 0mm), x_size=0.2mm, y_size=25.2mm)
  Rectangle37.unite(Rectangle36)
  Rectangle38 = rectangle(corner=(-26mm, 24.6mm, 0mm), x_size=25.9mm, y_size=0.25mm)
  Rectangle37.unite(Rectangle38, Rectangle35, XFeedr1)
  Rectangle39 = rectangle(corner=(22.7mm, -0.2mm, 0mm), x_size=7.3mm, y_size=0.4mm)
  Rectangle40 = rectangle(corner=(-0.2mm, -21.7mm, 0mm), x_size=0.4mm, y_size=-3.9mm)
  Rectangle41 = rectangle(corner=(0.2mm, -25.6mm, 0mm), x_size=26.8mm, y_size=0.45mm)
  Rectangle42 = rectangle(corner=(26.8mm, -25.15mm, 0mm), x_size=0.2mm, y_size=24.95mm)
  XFeedr.unite(XFeed_1, Rectangle41, Rectangle42, Rectangle40, Rectangle39)
  Box1 [vacuum] = box(corner=(-50mm, -50mm, -50mm), size=(100mm, 100mm, 100mm))
  Rectangle43 = rectangle(corner=(0.4mm, 30mm, 0.508mm), z_size=0.5mm, x_size=-0.8mm)
  Rectangle44 = rectangle(corner=(0.1mm, 30mm, 0mm), z_size=0.3mm, x_size=-0.2mm)
  Rectangle45 = rectangle(corner=(30mm, -0.2mm, 0mm), y_size=0.4mm, z_size=0.9mm)
  Rectangle46 = rectangle(corner=(-0.4mm, -30mm, 0.508mm), z_size=0.5mm, x_size=0.8mm)
  Rectangle47 = rectangle(corner=(-30mm, -16.8mm, 0mm), y_size=-1.2mm, z_size=0.5mm)
  group KaPatch_Group = KaPatch11..KaPatch26, KaPatch35..KaPatch50
  group KuPatch1_Group = KuPatch1_5..KuPatch1_20
  group XPatch_Group = XPatch1..XPatch4
boundaries and excitations:
  PerfE1: Perfect E Objects=Ground
  PerfE2: Perfect E Objects=Rectangle1
  PerfE3: Perfect E Objects=Rectangle16
  PerfE4: Perfect E Objects=Rectangle34
  PerfE5: Perfect E Objects=Rectangle37
  PerfE6: Perfect E Objects=XFeedr
  PerfE7: Perfect E Objects=XPatch1
  PerfE8: Perfect E Objects=XPatch2
  PerfE9: Perfect E Objects=XPatch3
  PerfE10: Perfect E Objects=XPatch4
  PerfE11: Perfect E Objects=[KaPatch50, KaPatch48, KaPatch49, KaPatch47, KaPatch46, KaPatch45, KaPatch44, KaPatch43, KaPatch42, KaPatch41, KaPatch40, KaPatch39, KaPatch38, KaPatch37, KaPatch36, KaPatch35, KaPatch26, KaPatch25, KaPatch24, KaPatch23, KaPatch21, KaPatch22, KaPatch20, KaPatch19, KaPatch18, KaPatch17, KaPatch16, KaPatch15, KaPatch14, KaPatch13, KaPatch12, KaPatch11]
  PerfE12: Perfect E Objects=[KuPatch1_5..KuPatch1_20]
  Rad1: Radiation Objects=Box1
  Rectangle1_T1: Terminal port=1 Edges=Rectangle1.edge(at (0, 30, 0.508)) TerminalResistance=50ohm
  Rectangle37_T1: Terminal port=2 Edges=Rectangle37.edge(at (0, 30, 0)) TerminalResistance=50ohm
  Rectangle16_T1: Terminal port=3 Edges=Rectangle16.edge(at (0, -30, 0.508)) TerminalResistance=50ohm
  XFeedr_T1: Terminal port=4 Edges=XFeedr.edge(at (30, 0, 0)) TerminalResistance=50ohm
  Rectangle34_T1: Terminal port=5 Edges=Rectangle34.edge(at (-30, -17.4, 0)) TerminalResistance=50ohm
  1: Lumped Port Faces=Rectangle43.face LumpedPortType=Terminal Impedance=50ohm
  2: Lumped Port Faces=Rectangle44.face LumpedPortType=Terminal Impedance=50ohm
  3: Lumped Port Faces=Rectangle46.face LumpedPortType=Terminal Impedance=50ohm
  4: Lumped Port Faces=Rectangle45.face LumpedPortType=Terminal Impedance=50ohm
  5: Lumped Port Faces=Rectangle47.face LumpedPortType=Terminal Impedance=50ohm
  reference conductors: Ground
source amplitudes:
  1:1: 1V 0deg
  2:1, 3:1, 4:1, 5:1: 0V 0deg
